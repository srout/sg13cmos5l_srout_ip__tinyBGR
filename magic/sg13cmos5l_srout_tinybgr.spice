* NGSPICE file created from sg13cmos5l_srout_tinybgr.ext - technology: ihp-sg13cmos5l

.subckt sg13cmos5l_srout_tinybgr AVDD VREF IOUT1 AVSS
X0 XR27.R1_4 XR27.R2_5 AVSS.t33 rhigh l=4u w=1.1u
X1 XR27.R1_12 XR27.R2_11 AVSS.t35 rhigh l=4u w=1.1u
X2 AVSS.t29 VREF XMPSU1.D0 AVSS.t42 sg13_hv_nmos ad=0.34p pd=2.68u as=0.34p ps=2.68u w=1u l=1u
X3 XR27.R1_18 XR27.R2_19 AVSS.t40 rhigh l=4u w=1.1u
X4 AVDD AVDD VREF AVDD sg13_hv_pmos ad=0.19p pd=1.38u as=0.19p ps=1.38u w=1u l=4u
X5 AVDD AVDD AVDD AVDD sg13_hv_pmos ad=0.34p pd=2.68u as=0.14595n ps=0.60425m w=1u l=4u
X6 IOUT1 XMP2.G2 AVDD AVDD sg13_hv_pmos ad=0.19p pd=1.38u as=0.19p ps=1.38u w=1u l=4u
X7 IOUT1 XMP2.G2 AVDD AVDD sg13_hv_pmos ad=0.19p pd=1.38u as=0.19p ps=1.38u w=1u l=4u
X8 XMP2.G2.t6 XMP2.S7_0 XR27.R2_15 AVSS.t23 sg13_hv_nmos ad=0.494p pd=2.98u as=0.494p ps=2.98u w=2.6u l=1u
X9 XMP2.S7_0 AVSS AVSS AVSS.t77 sg13_hv_nmos ad=0.494p pd=2.98u as=0.494p ps=2.98u w=2.6u l=1u
X10 AVSS AVSS.t83 XMP2.G2.t7 AVSS.t84 sg13_hv_nmos ad=0.494p pd=2.98u as=0.494p ps=2.98u w=2.6u l=1u
X11 VREF XR27.R2_31 AVSS.t55 rhigh l=4u w=1.1u
X12 XR27.R1_18 XR27.R2_17 AVSS.t41 rhigh l=4u w=1.1u
X13 AVDD AVDD AVDD AVDD sg13_hv_pmos ad=0.19p pd=1.38u as=0 ps=0 w=1u l=4u
X14 AVSS.t63 AVSS.t60 XR27.R2_14 pnpMPA a=1.4p p=5.4u
**devattr d=26292643,41169
X15 XR27.R1_24 XR27.R2_25 AVSS.t43 rhigh l=4u w=1.1u
X16 XR27.R1_10 XR27.R2_11 AVSS.t5 rhigh l=4u w=1.1u
X17 IOUT1 XMP2.G2 AVDD AVDD sg13_hv_pmos ad=0.19p pd=1.38u as=0.19p ps=1.38u w=1u l=4u
X18 AVDD XMP2.G2 XMP2.G2.t10 AVDD sg13_hv_pmos ad=0.19p pd=1.38u as=0.19p ps=1.38u w=1u l=4u
X19 AVSS.t81 AVSS.t60 XR27.R2_4 pnpMPA a=1.4p p=5.4u
**devattr d=26292643,41169
X20 IOUT1 XMP2.G2 AVDD AVDD sg13_hv_pmos ad=0.19p pd=1.38u as=0.19p ps=1.38u w=1u l=4u
X21 XMP2.G2.t4 AVSS AVSS AVSS.t99 sg13_hv_nmos ad=0.494p pd=2.98u as=0.494p ps=2.98u w=2.6u l=1u
X22 XMP2.G2.t2 XMP2.S7_0 XR27.R2_15 AVSS.t11 sg13_hv_nmos ad=0.494p pd=2.98u as=0.494p ps=2.98u w=2.6u l=1u
X23 XR27.R2_15 XMP2.S7_0 XMP2.G2.t5 AVSS.t22 sg13_hv_nmos ad=0.494p pd=2.98u as=0.494p ps=2.98u w=2.6u l=1u
X24 AVSS.t28 AVSS.t29 AVSS.t39 rhigh l=4u w=1.1u
X25 XMP2.G2.t7 XMP2.S7_0 XR27.R2_15 AVSS.t25 sg13_hv_nmos ad=0.494p pd=2.98u as=0.494p ps=2.98u w=2.6u l=1u
X26 XR27.R1_10 XR27.R2_9 AVSS.t2 rhigh l=4u w=1.1u
X27 AVDD XMP2.G2 XMP2.G2.t8 AVDD sg13_hv_pmos ad=0.19p pd=1.38u as=0.19p ps=1.38u w=1u l=4u
X28 XMPSU1.S2 VREF AVDD AVDD sg13_hv_pmos ad=0.119p pd=1.38u as=0.119p ps=1.38u w=0.35u l=6u
X29 XR27.R2_15 XMP2.S7_0 XMP2.G2.t1 AVSS.t10 sg13_hv_nmos ad=0.494p pd=2.98u as=0.494p ps=2.98u w=2.6u l=1u
X30 XMP2.G2.t5 XMP2.S7_0 XR27.R2_15 AVSS.t21 sg13_hv_nmos ad=0.494p pd=2.98u as=0.494p ps=2.98u w=2.6u l=1u
X31 XMPSU1.S2 VREF XMPSU1.D1 AVDD sg13_hv_pmos ad=0.119p pd=1.38u as=0.119p ps=1.38u w=0.35u l=6u
X32 XR27.R1_16 XR27.R2_17 AVSS.t30 rhigh l=4u w=1.1u
X33 XR27.R1_30 XR27.R2_31 AVSS.t58 rhigh l=4u w=1.1u
X34 XR27.R1_24 XR27.R2_23 AVSS.t44 rhigh l=4u w=1.1u
X35 VREF XMP2.G2 AVDD AVDD sg13_hv_pmos ad=0.19p pd=1.38u as=0.19p ps=1.38u w=1u l=4u
X36 XMP2.S7_0 XMPSU1.D0 AVDD AVSS.t26 sg13_hv_nmos ad=0.34p pd=2.68u as=0.34p ps=2.68u w=1u l=2u
X37 AVSS.t73 AVSS.t60 XR27.R2_14 pnpMPA a=1.4p p=5.4u
**devattr d=26292643,41169
X38 AVDD XMP2.G2 AVDD AVDD sg13_hv_pmos ad=0.19p pd=1.38u as=0 ps=0 w=1u l=4u
X39 XMP2.S7_0 XMP2.S7_0 XR27.R2_4 AVSS.t19 sg13_hv_nmos ad=0.494p pd=2.98u as=0.494p ps=2.98u w=2.6u l=1u
X40 AVSS.t93 AVSS.t91 AVSS.t93 AVSS.t92 sg13_hv_nmos ad=0.884p pd=5.88u as=0 ps=0 w=2.6u l=1u
X41 AVSS.t28 AVSS.t29 AVSS.t37 rhigh l=4u w=1.1u
X42 XMP2.G2.t1 XMP2.S7_0 XR27.R2_15 AVSS.t9 sg13_hv_nmos ad=0.494p pd=2.98u as=0.494p ps=2.98u w=2.6u l=1u
X43 XR27.R1_30 XR27.R2_29 AVSS.t51 rhigh l=4u w=1.1u
X44 AVSS.t61 AVSS.t60 XR27.R2_14 pnpMPA a=1.4p p=5.4u
**devattr d=26292643,41169
X45 XR27.R2_15 XMP2.S7_0 XMP2.G2.t4 AVSS.t20 sg13_hv_nmos ad=0.494p pd=2.98u as=0.494p ps=2.98u w=2.6u l=1u
X46 XR27.R2_15 XMP2.S7_0 XMP2.G2.t2 AVSS.t12 sg13_hv_nmos ad=0.494p pd=2.98u as=0.494p ps=2.98u w=2.6u l=1u
X47 XR27.R1_22 XR27.R2_23 AVSS.t46 rhigh l=4u w=1.1u
X48 XR27.R1_8 XR27.R2_9 AVSS.t6 rhigh l=4u w=1.1u
X49 AVDD AVDD XMP2.S7_0 AVDD sg13_hv_pmos ad=0.19p pd=1.38u as=0.19p ps=1.38u w=1u l=4u
X50 AVSS.t49 AVSS.t50 AVSS.t104 rhigh l=4u w=1.1u
X51 XR27.R1_16 XR27.R2_13 AVSS.t105 rhigh l=4u w=1.1u
X52 XMPSU1.S1 VREF XMPSU1.D1 AVDD sg13_hv_pmos ad=0.119p pd=1.38u as=0.119p ps=1.38u w=0.35u l=6u
X53 AVDD XMP2.G2 AVDD AVDD sg13_hv_pmos ad=0.19p pd=1.38u as=0 ps=0 w=1u l=4u
X54 XMP2.G2.t10 XMP2.G2 AVDD AVDD sg13_hv_pmos ad=0.19p pd=1.38u as=0.19p ps=1.38u w=1u l=4u
X55 AVDD XMP2.G2 VREF AVDD sg13_hv_pmos ad=0.19p pd=1.38u as=0.19p ps=1.38u w=1u l=4u
X56 AVDD AVDD AVDD AVDD sg13_hv_pmos ad=0.19p pd=1.38u as=0 ps=0 w=1u l=4u
X57 XR27.R1_8 XR27.R2_7 AVSS.t34 rhigh l=4u w=1.1u
X58 XMPSU1.S1 VREF XMPSU1.D0 AVDD sg13_hv_pmos ad=0.119p pd=1.38u as=0.119p ps=1.38u w=0.35u l=6u
X59 XR27.R2_15 XMP2.S7_0 XMP2.G2.t0 AVSS.t8 sg13_hv_nmos ad=0.494p pd=2.98u as=0.494p ps=2.98u w=2.6u l=1u
X60 XR27.R1_28 XR27.R2_29 AVSS.t45 rhigh l=4u w=1.1u
X61 XR27.R1_14 XR27.R2_15 AVSS.t3 rhigh l=4u w=1.1u
X62 XMP2.G2.t8 XMP2.G2 AVDD AVDD sg13_hv_pmos ad=0.19p pd=1.38u as=0.19p ps=1.38u w=1u l=4u
X63 AVSS.t65 AVSS.t60 XR27.R2_14 pnpMPA a=1.4p p=5.4u
**devattr d=26292643,41169
X64 AVSS.t28 AVSS.t29 AVSS.t27 rhigh l=4u w=1.1u
X65 XR27.R1_22 XR27.R2_21 AVSS.t47 rhigh l=4u w=1.1u
X66 AVSS.t75 AVSS.t60 XR27.R2_14 pnpMPA a=1.4p p=5.4u
**devattr d=26292643,41169
X67 AVSS.t49 AVSS.t50 AVSS.t48 rhigh l=4u w=1.1u
X68 XMP2.G2.t12 XMP2.G2 AVDD AVDD sg13_hv_pmos ad=0.19p pd=1.38u as=0.19p ps=1.38u w=1u l=4u
X69 AVDD AVDD AVDD AVDD sg13_hv_pmos ad=0.19p pd=1.38u as=0 ps=0 w=1u l=4u
X70 AVDD AVDD IOUT1 AVDD sg13_hv_pmos ad=0.19p pd=1.38u as=0.19p ps=1.38u w=1u l=4u
X71 AVDD XMP2.G2 IOUT1 AVDD sg13_hv_pmos ad=0.19p pd=1.38u as=0.19p ps=1.38u w=1u l=4u
X72 XR27.R1_28 XR27.R2_27 AVSS.t52 rhigh l=4u w=1.1u
X73 AVSS.t49 AVSS.t50 AVSS.t59 rhigh l=4u w=1.1u
X74 XR27.R1_6 XR27.R2_7 AVSS.t4 rhigh l=4u w=1.1u
X75 AVDD XMP2.G2 AVDD AVDD sg13_hv_pmos ad=0.19p pd=1.38u as=0 ps=0 w=1u l=4u
X76 XMP2.S7_0 XMP2.S7_0 XR27.R2_4 AVSS.t17 sg13_hv_nmos ad=0.494p pd=2.98u as=0.494p ps=2.98u w=2.6u l=1u
X77 XMP2.G2.t0 AVSS.t94 AVSS.t93 AVSS.t95 sg13_hv_nmos ad=0.494p pd=2.98u as=0.494p ps=2.98u w=2.6u l=1u
X78 AVSS AVSS XMP2.S7_0 AVSS.t79 sg13_hv_nmos ad=0.494p pd=2.98u as=0.494p ps=2.98u w=2.6u l=1u
X79 XR27.R1_14 XR27.R2_14 AVSS.t0 rhigh l=4u w=1.1u
X80 AVDD AVDD AVDD AVDD sg13_hv_pmos ad=0.19p pd=1.38u as=0 ps=0 w=1u l=4u
X81 XMP2.S7_0 XMP2.G2 AVDD AVDD sg13_hv_pmos ad=0.19p pd=1.38u as=0.19p ps=1.38u w=1u l=4u
X82 XR27.R1_20 XR27.R2_21 AVSS.t31 rhigh l=4u w=1.1u
X83 AVDD XMP2.G2 AVDD AVDD sg13_hv_pmos ad=0.19p pd=1.38u as=0 ps=0 w=1u l=4u
X84 AVDD AVDD AVDD AVDD sg13_hv_pmos ad=0.34p pd=2.68u as=0 ps=0 w=1u l=4u
X85 AVSS.t67 AVSS.t60 XR27.R2_14 pnpMPA a=1.4p p=5.4u
**devattr d=26292643,41169
X86 VREF XMP2.G2 AVDD AVDD sg13_hv_pmos ad=0.19p pd=1.38u as=0.19p ps=1.38u w=1u l=4u
X87 IOUT1 XMP2.G2 AVDD AVDD sg13_hv_pmos ad=0.19p pd=1.38u as=0.19p ps=1.38u w=1u l=4u
X88 AVSS AVSS.t60 AVSS pnpMPA a=1.4p p=5.4u
**devattr d=26292643,41169
X89 AVSS.t71 AVSS.t60 XR27.R2_14 pnpMPA a=1.4p p=5.4u
**devattr d=26292643,41169
X90 XR27.R1_26 XR27.R2_27 AVSS.t53 rhigh l=4u w=1.1u
X91 XR27.R2_4 XMP2.S7_0 XMP2.S7_0 AVSS.t16 sg13_hv_nmos ad=0.494p pd=2.98u as=0.494p ps=2.98u w=2.6u l=1u
X92 XR27.R1_20 XR27.R2_19 AVSS.t36 rhigh l=4u w=1.1u
X93 AVSS.t49 AVSS.t50 AVSS.t57 rhigh l=4u w=1.1u
X94 XR27.R2_4 XMP2.S7_0 XMP2.S7_0 AVSS.t18 sg13_hv_nmos ad=0.494p pd=2.98u as=0.494p ps=2.98u w=2.6u l=1u
X95 AVDD XMP2.G2 XMP2.S7_0 AVDD sg13_hv_pmos ad=0.19p pd=1.38u as=0.19p ps=1.38u w=1u l=4u
X96 IOUT1 XMP2.G2 AVDD AVDD sg13_hv_pmos ad=0.19p pd=1.38u as=0.19p ps=1.38u w=1u l=4u
X97 AVSS AVSS.t102 AVSS AVSS.t103 sg13_hv_nmos ad=0.494p pd=2.98u as=0.20972n ps=1.04194m w=2.6u l=1u
X98 AVSS.t49 AVSS.t50 AVSS.t54 rhigh l=4u w=1.1u
X99 XR27.R1_26 XR27.R2_25 AVSS.t56 rhigh l=4u w=1.1u
X100 AVSS.t28 AVSS.t29 AVSS.t32 rhigh l=4u w=1.1u
X101 AVDD AVDD AVDD AVDD sg13_hv_pmos ad=0.19p pd=1.38u as=0 ps=0 w=1u l=4u
X102 AVSS AVSS.t60 AVSS pnpMPA a=1.4p p=5.4u
**devattr d=26292643,41169
X103 AVDD XMP2.G2 XMP2.G2.t12 AVDD sg13_hv_pmos ad=0.19p pd=1.38u as=0.19p ps=1.38u w=1u l=4u
X104 AVSS.t69 AVSS.t60 XR27.R2_14 pnpMPA a=1.4p p=5.4u
**devattr d=26292643,41169
X105 AVDD XMP2.G2 IOUT1 AVDD sg13_hv_pmos ad=0.19p pd=1.38u as=0.19p ps=1.38u w=1u l=4u
X106 AVSS AVSS XMP2.G2.t3 AVSS.t85 sg13_hv_nmos ad=0.494p pd=2.98u as=0.494p ps=2.98u w=2.6u l=1u
X107 XR27.R1_4 XR27.R2_4 AVSS.t38 rhigh l=4u w=1.1u
X108 AVDD XMP2.G2 IOUT1 AVDD sg13_hv_pmos ad=0.19p pd=1.38u as=0.19p ps=1.38u w=1u l=4u
X109 XMP2.S7_0 XMP2.S7_0 XR27.R2_4 AVSS.t15 sg13_hv_nmos ad=0.494p pd=2.98u as=0.494p ps=2.98u w=2.6u l=1u
X110 XR27.R1_12 XR27.R2_13 AVSS.t7 rhigh l=4u w=1.1u
X111 AVDD AVDD AVDD AVDD sg13_hv_pmos ad=0.34p pd=2.68u as=0 ps=0 w=1u l=4u
X112 XR27.R1_6 XR27.R2_5 AVSS.t1 rhigh l=4u w=1.1u
X113 AVDD XMP2.G2 IOUT1 AVDD sg13_hv_pmos ad=0.19p pd=1.38u as=0.19p ps=1.38u w=1u l=4u
X114 XMP2.S7_0 XMP2.G2 AVDD AVDD sg13_hv_pmos ad=0.19p pd=1.38u as=0.19p ps=1.38u w=1u l=4u
X115 AVDD AVDD AVDD AVDD sg13_hv_pmos ad=0.19p pd=1.38u as=0 ps=0 w=1u l=4u
X116 AVDD XMP2.G2 IOUT1 AVDD sg13_hv_pmos ad=0.19p pd=1.38u as=0.19p ps=1.38u w=1u l=4u
X117 XMP2.G2.t3 XMP2.S7_0 XR27.R2_15 AVSS.t13 sg13_hv_nmos ad=0.494p pd=2.98u as=0.494p ps=2.98u w=2.6u l=1u
X118 XR27.R2_15 XMP2.S7_0 XMP2.G2.t6 AVSS.t24 sg13_hv_nmos ad=0.494p pd=2.98u as=0.494p ps=2.98u w=2.6u l=1u
X119 XR27.R2_4 XMP2.S7_0 XMP2.S7_0 AVSS.t14 sg13_hv_nmos ad=0.494p pd=2.98u as=0.494p ps=2.98u w=2.6u l=1u
R0 AVSS.n42 AVSS.n35 132024
R1 AVSS.n41 AVSS.t61 3788.46
R2 AVSS.t7 AVSS.t75 3788.46
R3 AVSS.t63 AVSS.t61 3487.18
R4 AVSS.t65 AVSS.t63 3487.18
R5 AVSS.t67 AVSS.t65 3487.18
R6 AVSS.t69 AVSS.t81 3487.18
R7 AVSS.t71 AVSS.t69 3487.18
R8 AVSS.t73 AVSS.t71 3487.18
R9 AVSS.t75 AVSS.t73 3487.18
R10 AVSS.n41 AVSS.n40 818.961
R11 AVSS.t37 AVSS.t27 398.99
R12 AVSS.t33 AVSS.t38 398.99
R13 AVSS.t4 AVSS.t1 398.99
R14 AVSS.t6 AVSS.t34 398.99
R15 AVSS.t35 AVSS.t5 398.99
R16 AVSS.t2 AVSS.t73 386.365
R17 AVSS.t75 AVSS.t2 300.505
R18 AVSS.t81 AVSS.t39 289.031
R19 AVSS.t39 AVSS.t67 284.812
R20 AVSS.n42 AVSS.n40 275.289
R21 AVSS.t34 AVSS.t71 275.253
R22 AVSS.n41 AVSS.t26 258.601
R23 AVSS.t32 AVSS.n38 257.442
R24 AVSS.t16 AVSS.t15 250
R25 AVSS.t22 AVSS.t21 250
R26 AVSS.t7 AVSS.t35 248.738
R27 AVSS.t11 AVSS.t40 235.507
R28 AVSS.t55 AVSS.t20 235.507
R29 AVSS.t69 AVSS.t33 234.849
R30 AVSS.t63 AVSS.t42 234.249
R31 AVSS.t43 AVSS.t14 231.885
R32 AVSS.t8 AVSS.t41 228.262
R33 AVSS.t23 AVSS.t54 228.262
R34 AVSS.n43 AVSS.n42 223.811
R35 AVSS.t12 AVSS.t36 199.275
R36 AVSS.t58 AVSS.t99 199.275
R37 AVSS.t44 AVSS.t77 195.653
R38 AVSS.t18 AVSS.t53 195.653
R39 AVSS.t95 AVSS.t30 192.03
R40 AVSS.t24 AVSS.t57 192.03
R41 AVSS.t27 AVSS.t65 182.411
R42 AVSS.n36 AVSS.n38 173.947
R43 AVSS.t104 AVSS.t84 166.667
R44 AVSS.t1 AVSS.t69 164.142
R45 AVSS.t13 AVSS.t31 163.043
R46 AVSS.t51 AVSS.t79 163.043
R47 AVSS.t46 AVSS.t85 159.421
R48 AVSS.t19 AVSS.t52 159.421
R49 AVSS.t92 AVSS.t105 155.798
R50 AVSS.t25 AVSS.t59 155.798
R51 AVSS.t65 AVSS.t32 155.393
R52 AVSS.n44 AVSS.n39 147.645
R53 AVSS.n43 AVSS.n41 135.679
R54 AVSS.t3 AVSS.t92 130.435
R55 AVSS.t48 AVSS.t25 130.435
R56 AVSS.t10 AVSS 128.624
R57 AVSS.t85 AVSS.t47 126.812
R58 AVSS.t45 AVSS.t19 126.812
R59 AVSS.t17 AVSS 125.001
R60 AVSS.t71 AVSS.t4 123.737
R61 AVSS.t47 AVSS.t13 123.189
R62 AVSS.t79 AVSS.t45 123.189
R63 AVSS.n30 AVSS.t61 121.624
R64 AVSS.t9 AVSS 121.377
R65 AVSS.t84 AVSS.t48 119.566
R66 AVSS.n45 AVSS.t103 117.754
R67 AVSS.t0 AVSS.t7 106.885
R68 AVSS AVSS.t56 106.885
R69 AVSS.n45 AVSS.n35 99.6382
R70 AVSS.t5 AVSS.t75 98.4853
R71 AVSS.t105 AVSS.t95 94.2034
R72 AVSS.t59 AVSS.t24 94.2034
R73 AVSS.t77 AVSS.t46 90.5802
R74 AVSS.t52 AVSS.t18 90.5802
R75 AVSS.n39 AVSS.t3 86.957
R76 AVSS.t31 AVSS.t12 86.957
R77 AVSS.t99 AVSS.t51 86.957
R78 AVSS.t103 AVSS.t104 83.3338
R79 AVSS.t67 AVSS.t37 58.0813
R80 AVSS.t30 AVSS.t8 57.9715
R81 AVSS.t57 AVSS.t23 57.9715
R82 AVSS.t14 AVSS.t44 54.3483
R83 AVSS.t53 AVSS.t17 54.3483
R84 AVSS.t38 AVSS.t81 53.0308
R85 AVSS.n44 AVSS.t0 51.6309
R86 AVSS.t36 AVSS.t11 50.7251
R87 AVSS.t20 AVSS.t58 50.7251
R88 AVSS.t63 AVSS.n36 44.067
R89 AVSS.n37 AVSS.t61 35.8337
R90 AVSS.t41 AVSS.t9 21.7396
R91 AVSS.t54 AVSS.t22 21.7396
R92 AVSS.t29 AVSS.n34 1.22566
R93 AVSS.t81 AVSS.n40 19.6106
R94 AVSS.t15 AVSS.t43 18.1164
R95 AVSS.t56 AVSS.t16 18.1164
R96 AVSS.t40 AVSS.t10 14.4933
R97 AVSS.t21 AVSS.t55 14.4933
R98 AVSS.t73 AVSS.t6 12.6268
R99 AVSS.n0 AVSS.t60 1.01038
R100 AVSS.n26 AVSS.t60 1.96405
R101 AVSS.n23 AVSS.t60 1.96405
R102 AVSS.n2 AVSS.t60 1.96405
R103 AVSS.n5 AVSS.t60 1.96405
R104 AVSS.n8 AVSS.t60 1.96405
R105 AVSS.n11 AVSS.t60 1.96405
R106 AVSS.n14 AVSS.t60 1.96405
R107 AVSS.n17 AVSS.t60 1.96405
R108 AVSS.n20 AVSS.t60 1.96405
R109 AVSS.t102 AVSS.n33 3.75175
R110 AVSS.t91 AVSS.t93 3.55816
R111 AVSS.t83 AVSS.n33 4.13675
R112 AVSS.t93 AVSS.t94 3.99824
R113 AVSS.n37 AVSS.n43 3.4005
R114 AVSS.n30 AVSS.n31 0.321054
R115 AVSS.n30 AVSS.n36 3.4005
R116 AVSS.t60 AVSS.n25 2.83383
R117 AVSS.n22 AVSS.t60 2.83383
R118 AVSS.n1 AVSS.t60 2.83383
R119 AVSS.n4 AVSS.t60 2.83383
R120 AVSS.n7 AVSS.t60 2.83383
R121 AVSS.n10 AVSS.t60 2.83383
R122 AVSS.n13 AVSS.t60 2.83383
R123 AVSS.n16 AVSS.t60 2.83383
R124 AVSS.n19 AVSS.t60 2.83383
R125 AVSS.n28 AVSS.t60 2.83383
R126 AVSS.t81 AVSS.n0 2.09809
R127 AVSS.n32 AVSS.t60 1.92629
R128 AVSS AVSS.n39 1.88939
R129 AVSS AVSS.n35 1.88939
R130 AVSS AVSS.n33 1.8487
R131 AVSS.t81 AVSS.n44 1.7005
R132 AVSS.t42 AVSS.n30 1.67114
R133 AVSS.t93 AVSS.n32 1.4849
R134 AVSS.t49 AVSS 1.38293
R135 AVSS.n34 AVSS.t28 1.44222
R136 AVSS AVSS.t50 1.36775
R137 AVSS.n29 AVSS.n0 0.638566
R138 AVSS.n32 AVSS.n27 1.20228
R139 AVSS AVSS.n34 1.06188
R140 AVSS.t93 AVSS.n25 1.16925
R141 AVSS AVSS.t93 1.15725
R142 AVSS.n31 AVSS.n37 1.82583
R143 AVSS.n27 AVSS.n26 1.51506
R144 AVSS.n24 AVSS.n23 1.51506
R145 AVSS.n21 AVSS.n20 1.51506
R146 AVSS.n18 AVSS.n17 1.51506
R147 AVSS.n15 AVSS.n14 1.51506
R148 AVSS.n12 AVSS.n11 1.51506
R149 AVSS.n9 AVSS.n8 1.51506
R150 AVSS.n6 AVSS.n5 1.51506
R151 AVSS.n3 AVSS.n2 1.51506
R152 AVSS.t93 AVSS.t81 1.37059
R153 AVSS.n31 AVSS.t29 0.552388
R154 AVSS AVSS.n45 1.063
R155 AVSS AVSS.n38 1.063
R156 AVSS.t26 AVSS.n37 1.06142
R157 AVSS.n29 AVSS.n28 0.9355
R158 AVSS.n28 AVSS.n21 0.9355
R159 AVSS.n21 AVSS.n19 0.9355
R160 AVSS.n19 AVSS.n18 0.9355
R161 AVSS.n18 AVSS.n16 0.9355
R162 AVSS.n16 AVSS.n15 0.9355
R163 AVSS.n15 AVSS.n13 0.9355
R164 AVSS.n13 AVSS.n12 0.9355
R165 AVSS.n12 AVSS.n10 0.9355
R166 AVSS.n10 AVSS.n9 0.9355
R167 AVSS.n9 AVSS.n7 0.9355
R168 AVSS.n7 AVSS.n6 0.9355
R169 AVSS.n6 AVSS.n4 0.9355
R170 AVSS.n4 AVSS.n3 0.9355
R171 AVSS.n3 AVSS.n1 0.9355
R172 AVSS.n1 AVSS.n24 0.9355
R173 AVSS.n24 AVSS.n22 0.9355
R174 AVSS.n22 AVSS.n27 0.9355
R175 AVSS.n27 AVSS.n25 0.9355
R176 AVSS.n20 AVSS.n29 1.15194
R177 AVSS.n17 AVSS.n21 1.15194
R178 AVSS.n14 AVSS.n18 1.15194
R179 AVSS.n11 AVSS.n15 1.15194
R180 AVSS.n8 AVSS.n12 1.15194
R181 AVSS.n5 AVSS.n9 1.15194
R182 AVSS.n2 AVSS.n6 1.15194
R183 AVSS.n23 AVSS.n3 1.15194
R184 AVSS.n26 AVSS.n24 1.15194
R185 XMP2.G2.n2 XMP2.G2.n11 11.0053
R186 XMP2.G2.n4 XMP2.G2 9.78529
R187 XMP2.G2.n8 XMP2.G2 9.78529
R188 XMP2.G2.n6 XMP2.G2 9.78387
R189 XMP2.G2 XMP2.G2.n1 8.71441
R190 XMP2.G2.n0 XMP2.G2 7.87108
R191 XMP2.G2.n1 XMP2.G2 7.87108
R192 XMP2.G2.n1 XMP2.G2 7.87108
R193 XMP2.G2.n3 XMP2.G2 7.79297
R194 XMP2.G2.n3 XMP2.G2 7.79297
R195 XMP2.G2.n2 XMP2.G2 7.79297
R196 XMP2.G2.n2 XMP2.G2 7.79297
R197 XMP2.G2.n7 XMP2.G2 7.33662
R198 XMP2.G2.n4 XMP2.G2 6.02553
R199 XMP2.G2.n6 XMP2.G2 6.02553
R200 XMP2.G2.n5 XMP2.G2 6.02553
R201 XMP2.G2.n10 XMP2.G2 6.02553
R202 XMP2.G2.n9 XMP2.G2 6.02553
R203 XMP2.G2.n8 XMP2.G2 6.02553
R204 XMP2.G2.n7 XMP2.G2 6.02553
R205 XMP2.G2 XMP2.G2.t8 5.66717
R206 XMP2.G2 XMP2.G2.t10 5.66717
R207 XMP2.G2 XMP2.G2.t12 5.66717
R208 XMP2.G2.n11 XMP2.G2.n4 4.99104
R209 XMP2.G2.n0 XMP2.G2.n3 4.12116
R210 XMP2.G2 XMP2.G2.t7 2.83383
R211 XMP2.G2 XMP2.G2.t3 2.83383
R212 XMP2.G2 XMP2.G2.t2 2.83383
R213 XMP2.G2 XMP2.G2.t1 2.83383
R214 XMP2.G2 XMP2.G2.t0 2.83383
R215 XMP2.G2 XMP2.G2.t4 2.83383
R216 XMP2.G2 XMP2.G2.t5 2.83383
R217 XMP2.G2 XMP2.G2.t6 2.83383
R218 XMP2.G2.n3 XMP2.G2.n2 2.46212
R219 XMP2.G2.n4 XMP2.G2.n6 2.13212
R220 XMP2.G2.n1 XMP2.G2.n0 1.68717
R221 XMP2.G2.n11 XMP2.G2 1.52553
R222 XMP2.G2.n5 XMP2.G2.n10 1.31158
R223 XMP2.G2.n10 XMP2.G2.n9 1.31158
R224 XMP2.G2.n9 XMP2.G2.n8 1.31158
R225 XMP2.G2.n8 XMP2.G2.n7 1.31158
R226 XMP2.G2.n6 XMP2.G2.n5 1.31158
C0 a_6888_590# a_7204_590# 0.13021f
C1 a_5308_590# a_5624_590# 0.13021f
C2 a_13208_590# a_12892_590# 0.13021f
C3 XR27.R2_13 a_6888_590# 0.11282f
C4 a_9732_590# a_10048_590# 0.13021f
C5 VREF IOUT1 4.33814f
C6 AVDD XMP2.G2 35.1237f
C7 a_10364_590# a_10680_590# 0.13021f
C8 a_4676_590# a_4360_590# 0.13021f
C9 a_7520_590# a_7204_590# 0.13021f
C10 VREF XMPSU1.D0 0.51388f
C11 VREF XMP2.S7_0 0.94089f
C12 a_13208_590# a_13524_590# 0.13021f
C13 a_3412_590# a_3096_590# 0.13021f
C14 a_12576_590# a_12892_590# 0.13021f
C15 AVDD XMPSU1.S1 0.14601f
C16 a_8784_590# a_9100_590# 0.13021f
C17 a_2148_590# a_2464_590# 0.13021f
C18 VREF XMP2.G2 4.8496f
C19 XMP2.S7_0 IOUT1 0.49858f
C20 XR27.R2_13 a_5940_590# 0.109f
C21 a_9416_590# a_9732_590# 0.13021f
C22 a_10996_590# a_10680_590# 0.13021f
C23 a_3728_590# a_4044_590# 0.13021f
C24 a_6572_590# a_6888_590# 0.13021f
C25 a_8152_590# a_8468_590# 0.13021f
C26 XMPSU1.D0 XMP2.S7_0 0.6321f
C27 a_5624_590# a_5940_590# 0.13021f
C28 a_8152_590# a_7836_590# 0.13021f
C29 XMP2.G2 IOUT1 5.11724f
C30 a_7520_590# a_7836_590# 0.13021f
C31 AVDD XMPSU1.D1 0.13916f
C32 a_10048_590# a_10364_590# 0.13021f
C33 XR27.R2_4 XMP2.S7_0 1.19068f
C34 XR27.R2_15 XMP2.S7_0 1.35335f
C35 XMP2.G2 XMP2.S7_0 6.83327f
C36 VREF AVDD 4.72564f
C37 a_6572_590# a_6256_590# 0.13021f
C38 a_2780_590# a_2464_590# 0.13021f
C39 XR27.R2_15 XR27.R2_4 3.2515f
C40 a_4992_590# a_4676_590# 0.13021f
C41 a_4992_590# a_5308_590# 0.13021f
C42 XR27.R2_4 XMP2.G2 6.40437f
C43 XR27.R2_13 XR27.R2_15 0.10564f
C44 a_11312_590# a_10996_590# 0.13021f
C45 XR27.R2_15 XMP2.G2 1.94223f
C46 a_8784_590# a_8468_590# 0.13021f
C47 a_1832_590# a_2148_590# 0.13021f
C48 a_11944_590# a_11628_590# 0.13021f
C49 AVDD XMPSU1.S2 0.14978f
C50 a_2780_590# a_3096_590# 0.13021f
C51 a_12576_590# a_12260_590# 0.13021f
C52 AVDD IOUT1 1.45303f
C53 a_9100_590# a_9416_590# 0.13021f
C54 a_4360_590# a_4044_590# 0.13021f
C55 a_11312_590# a_11628_590# 0.13021f
C56 XR27.R2_14 XR27.R2_4 0.28515f
C57 XR27.R2_13 XR27.R2_14 0.10795f
C58 XR27.R2_15 XR27.R2_14 0.13643f
C59 AVDD XMPSU1.D0 0.33859f
C60 a_3728_590# a_3412_590# 0.13021f
C61 a_6256_590# a_5940_590# 0.13021f
C62 XR27.R2_14 XMP2.G2 0.1046f
C63 AVDD XMP2.S7_0 4.42644f
C64 a_12260_590# a_11944_590# 0.13021f
C65 IOUT1 AVSS 32.44131f
C66 XR27.R2_31 AVSS 1.00073f
C67 XR27.R1_30 AVSS 0.97579f
C68 XR27.R2_29 AVSS 0.98818f
C69 XR27.R1_28 AVSS 0.97655f
C70 XR27.R2_27 AVSS 0.9794f
C71 XR27.R1_26 AVSS 0.97596f
C72 XR27.R2_25 AVSS 0.97722f
C73 XR27.R1_24 AVSS 0.97612f
C74 XR27.R2_23 AVSS 0.98519f
C75 XR27.R1_22 AVSS 0.97579f
C76 XR27.R2_21 AVSS 0.9822f
C77 XR27.R1_20 AVSS 0.97655f
C78 XR27.R2_19 AVSS 0.97803f
C79 XR27.R1_18 AVSS 0.97655f
C80 XR27.R2_17 AVSS 0.97844f
C81 XR27.R1_16 AVSS 0.97527f
C82 XR27.R2_15 AVSS 13.72225f
C83 XR27.R2_14 AVSS 11.0374f
C84 XR27.R1_14 AVSS 0.9751f
C85 XR27.R2_13 AVSS 1.15518f
C86 XR27.R1_12 AVSS 0.97689f
C87 XR27.R2_11 AVSS 0.99051f
C88 XR27.R1_10 AVSS 0.97655f
C89 XR27.R2_9 AVSS 0.98812f
C90 XR27.R1_8 AVSS 0.97578f
C91 XR27.R2_7 AVSS 0.98811f
C92 XR27.R1_6 AVSS 0.97655f
C93 XR27.R2_5 AVSS 0.98811f
C94 XR27.R2_4 AVSS 5.96253f
C95 XR27.R1_4 AVSS 1.00009f
C96 XMPSU1.S2 AVSS 1.1907f
C97 XMP2.G2.n0 AVSS 0.71988f
C98 XMP2.G2.n1 AVSS 0.83992f
C99 XMP2.G2.n2 AVSS 2.48184f
C100 XMP2.G2.n3 AVSS 1.03911f
C101 XMP2.G2.n4 AVSS 1.80847f
C102 XMP2.G2.n5 AVSS 0.38244f
C103 XMP2.G2.n6 AVSS 0.73901f
C104 XMP2.G2.n7 AVSS 1.25576f
C105 XMP2.G2.n8 AVSS 0.74303f
C106 XMP2.G2.n9 AVSS 0.44178f
C107 XMP2.G2.n10 AVSS 0.44178f
C108 XMP2.G2.n11 AVSS 1.87653f
C109 XMP2.G2.t0 AVSS 0.93459f
C110 XMP2.G2.t1 AVSS 0.1993f
C111 XMP2.G2.t2 AVSS 0.1993f
C112 XMP2.G2.t3 AVSS 0.1993f
C113 XMP2.G2.t4 AVSS 0.1993f
C114 XMP2.G2.t5 AVSS 0.1993f
C115 XMP2.G2.t6 AVSS 8.06145f
C116 XMP2.G2.t7 AVSS 0.1993f
C117 AVSS.t28 AVSS 1.36225f
C118 AVSS.t29 AVSS 3.18092f
C119 AVSS.t49 AVSS 1.72239f
C120 AVSS.t50 AVSS 1.72239f
.ends
