** sch_path: /foss/designs/gits/sg13cmos5l_srout_ip__tinyBGR/xschem/sg13cmos5l_srout_tinybgr.sch
.subckt sg13cmos5l_srout_tinybgr vdd_3v3 vbias ibias0 vss_3v3
*.PININFO vdd_3v3:B vss_3v3:B vbias:O ibias0:O
XQ1 vss_3v3 vss_3v3 Vbe1 pnpMPA a=1.4e-12 p=5.4e-06 m=8
XQ2 vss_3v3 vss_3v3 Vbe2 pnpMPA a=1.4e-12 p=5.4e-06
XMN2 Vgn Vgn Vbe2 vss_3v3 sg13_hv_nmos w=2.6u l=1u ng=1 m=6
XMN1 Vgp Vgn Vbe2mr vss_3v3 sg13_hv_nmos w=2.6u l=1u ng=1 m=12
XMP2 Vgn Vgp vdd_3v3 vdd_3v3 sg13_hv_pmos w=1u l=4u ng=1 m=3
XMP1 Vgp Vgp vdd_3v3 vdd_3v3 sg13_hv_pmos w=1u l=4u ng=1 m=6
XMP3 ibias0 Vgp vdd_3v3 vdd_3v3 sg13_hv_pmos w=1u l=4u ng=1 m=11
XMP5 vbias Vgp vdd_3v3 vdd_3v3 sg13_hv_pmos w=1u l=4u ng=1 m=3
XMNSU1 vdd_3v3 vgsu1 Vgn vss_3v3 sg13_hv_nmos w=1u l=2u ng=1 m=1
XMPSU1 net1 vbias vdd_3v3 vdd_3v3 sg13_hv_pmos w=0.35u l=6u ng=1 m=1
XMNSU2 vgsu1 vbias vss_3v3 vss_3v3 sg13_hv_nmos w=1u l=1u ng=1 m=1
XMPSU2 net2 vbias net1 vdd_3v3 sg13_hv_pmos w=0.35u l=6u ng=1 m=1
XMPSU3 net3 vbias net2 vdd_3v3 sg13_hv_pmos w=0.35u l=6u ng=1 m=1
XMPSU4 vgsu1 vbias net3 vdd_3v3 sg13_hv_pmos w=0.35u l=6u ng=1 m=1
xbgrres vbias Vbe2mr vss_3v3 Vbe2 Vbe1 sg13cmos5l_srout_tinybgr_res
XQ3 vss_3v3 vss_3v3 vss_3v3 pnpMPA a=1.4e-12 p=5.4e-06 m=2
XMN3 vss_3v3 vss_3v3 vss_3v3 vss_3v3 sg13_hv_nmos w=2.6u l=1u ng=1 m=2
XMN4 Vgn vss_3v3 vss_3v3 vss_3v3 sg13_hv_nmos w=2.6u l=1u ng=1 m=2
XMN5 Vgp vss_3v3 vss_3v3 vss_3v3 sg13_hv_nmos w=2.6u l=1u ng=1 m=4
XMP4 vdd_3v3 Vgp vdd_3v3 vdd_3v3 sg13_hv_pmos w=1u l=4u ng=1 m=4
XMP6 Vgn vdd_3v3 vdd_3v3 vdd_3v3 sg13_hv_pmos w=1u l=4u ng=1 m=1
XMP7 ibias0 vdd_3v3 vdd_3v3 vdd_3v3 sg13_hv_pmos w=1u l=4u ng=1 m=1
XMP8 vbias vdd_3v3 vdd_3v3 vdd_3v3 sg13_hv_pmos w=1u l=4u ng=1 m=1
XMP9 vdd_3v3 vdd_3v3 vdd_3v3 vdd_3v3 sg13_hv_pmos w=1u l=4u ng=1 m=9
.ends

* expanding   symbol:  sg13cmos5l_srout_tinybgr_res.sym # of pins=5
** sym_path: /foss/designs/gits/sg13cmos5l_srout_ip__tinyBGR/xschem/sg13cmos5l_srout_tinybgr_res.sym
** sch_path: /foss/designs/gits/sg13cmos5l_srout_ip__tinyBGR/xschem/sg13cmos5l_srout_tinybgr_res.sch
.subckt sg13cmos5l_srout_tinybgr_res Vref Vbe2mr AVSS Vbe2 Vbe1
*.PININFO Vbe1:B Vbe2:B AVSS:B Vbe2mr:B Vref:B
XR3 Vbe2mr net21 AVSS rhigh w=1.1u l=4u m=1 b=0
XR1 net21 Vbe1 AVSS rhigh w=1.1u l=4u m=1 b=0
XR2 net2 net1 AVSS rhigh w=1.1u l=4u m=1 b=0
XR4 net1 Vbe2 AVSS rhigh w=1.1u l=4u m=1 b=0
XR5 net3 net2 AVSS rhigh w=1.1u l=4u m=1 b=0
XR6 net4 net3 AVSS rhigh w=1.1u l=4u m=1 b=0
XR7 net22 net4 AVSS rhigh w=1.1u l=4u m=1 b=0
XR8 net6 net5 AVSS rhigh w=1.1u l=4u m=1 b=0
XR9 net5 net23 AVSS rhigh w=1.1u l=4u m=1 b=0
XR10 net7 net6 AVSS rhigh w=1.1u l=4u m=1 b=0
XR11 net8 net7 AVSS rhigh w=1.1u l=4u m=1 b=0
XR12 net22 net8 AVSS rhigh w=1.1u l=4u m=1 b=0
XR13 net10 net9 AVSS rhigh w=1.1u l=4u m=1 b=0
XR14 net9 net23 AVSS rhigh w=1.1u l=4u m=1 b=0
XR15 net11 net10 AVSS rhigh w=1.1u l=4u m=1 b=0
XR16 net12 net11 AVSS rhigh w=1.1u l=4u m=1 b=0
XR17 net24 net12 AVSS rhigh w=1.1u l=4u m=1 b=0
XR18 net14 net13 AVSS rhigh w=1.1u l=4u m=1 b=0
XR19 net13 net25 AVSS rhigh w=1.1u l=4u m=1 b=0
XR20 net15 net14 AVSS rhigh w=1.1u l=4u m=1 b=0
XR21 net16 net15 AVSS rhigh w=1.1u l=4u m=1 b=0
XR22 net24 net16 AVSS rhigh w=1.1u l=4u m=1 b=0
XR23 net18 net17 AVSS rhigh w=1.1u l=4u m=1 b=0
XR24 net17 net26 AVSS rhigh w=1.1u l=4u m=1 b=0
XR25 net19 net18 AVSS rhigh w=1.1u l=4u m=1 b=0
XR26 net20 net19 AVSS rhigh w=1.1u l=4u m=1 b=0
XR27 Vref net20 AVSS rhigh w=1.1u l=4u m=1 b=0
XR28 net25 net27 AVSS rhigh w=1.1u l=4u m=1 b=0
XR29 net26 net27 AVSS rhigh w=1.1u l=4u m=1 b=0
XR30 AVSS AVSS AVSS rhigh w=1.1u l=4u m=9 b=0
.ends
