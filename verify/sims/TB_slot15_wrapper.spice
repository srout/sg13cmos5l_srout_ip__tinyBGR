** sch_path: /foss/designs/gits/sg13cmos5l_srout_ip__tinyBGR/xschem/TB_tinybgr.sch
**.subckt TB_tinybgr
Vsup vdd_3v3 0 PAR_VDD3v3
Vgnd vss_3v3 0 0
C3 vbias 0 10f
Viout1 ibias0 0 1
*xbgrtop ADD5V vbias IOUT1 0 sg13cmos5l_srout_tinybgr
Xslot15_wrapper vss_3v3 s15_an[0] s15_an_0_esd vbias dig_in[23] dig_in[22]
+ dig_in[21] dig_in[20] dig_in[19] dig_in[18] dig_in[17] dig_in[16] dig_in[15] dig_in[14]
+ dig_in[13] dig_in[12] dig_in[11] dig_in[10] dig_in[9] dig_in[8] dig_in[7] dig_in[6]
+ dig_in[5] dig_in[4] dig_in[3] dig_in[2] dig_in[1] dig_in[0] dig_out[11] dig_out[10]
+ dig_out[9] dig_out[8] dig_out[7] dig_out[6] dig_out[5] dig_out[4] dig_out[3] dig_out[2]
+ dig_out[1] dig_out[0] ibias0 ibias1 analog_bus3 analog_bus2 analog_bus1 analog_bus0
+ vss_1v2 vdd_1v2 vdd_3v3 enable clk reset slot15_wrapper
**** begin user architecture code

.option savecurrents
.PARAM PAR_VDD3v3=3.3
.PARAM PAR_VDDRISE=100e-6
.PARAM PAR_POFF=0
.PARAM PAR_NOFF=0
.OPTION TEMP=27

.control
run
save all

op
**write tb_bgr_op.raw
** To find model parameters type display in ngspice prompt
**print @n.xbgrtop.xmn1.nsg13_hv_nmos[ids] @n.xbgrtop.xmn1.nsg13_hv_nmos[gm]
**print @n.xbgrtop.xmp1.nsg13_hv_pmos[ids] @n.xbgrtop.xmp1.nsg13_hv_pmos[gm]
**LET gmidmn1=@n.xbgrtop.xmn1.nsg13_hv_nmos[gm]/@n.xbgrtop.xmn1.nsg13_hv_nmos[ids]
**LET gmidmp1=@n.xbgrtop.xmp1.nsg13_hv_pmos[gm]/@n.xbgrtop.xmp1.nsg13_hv_pmos[ids]
**print gmidmn1 gmidmp1
**print @q.xbgrtop.xq2.qpnpmpa[ie] @q.xbgrtop.xq1.qpnpmpa[ie]
* dc Vref 3.3 1.5 -0.1
DC TEMP -30 125 1
**write dc.raw
PLOT V(vbias)
**PLOT I(VIOUT1)
** PLOT @n.xbgrtop.xmnsu1.nsg13_hv_nmos[ids]
**PLOT @n.xbgrtop.xmnsu2.nsg13_hv_nmos[ids]
**PLOT V(xbgrtop.vgsu1)
** Calculating tempco
*MEAS DC vrefMAX_m40to125 MAX V(vbias) FROM=-40 TO=125
*MEAS DC vrefMIN_m40to125 MIN V(vbias) FROM=-40 TO=125
MEAS DC vrefMAX_m30to85 MAX V(vbias) FROM=-30 TO=85
MEAS DC vrefMIN_m30to85 MIN V(vbias) FROM=-30 TO=85
MEAS DC vrefMAX_m20to85 MAX V(vbias) FROM=-20 TO=85
MEAS DC vrefMIN_m20to85 MIN V(vbias) FROM=-20 TO=85
MEAS DC Iout25 FIND I(VIOUT1) At=25

*LET tempco_m40_125_ppmC=1e6*(vrefMAX_m40to125 - vrefMIN_m40to125)/165/1.25
LET tempco_m30_85_ppmC=1e6*(vrefMAX_m30to85 - vrefMIN_m30to85)/115/1.25
LET tempco_m20_85_ppmC=1e6*(vrefMAX_m20to85 - vrefMIN_m20to85)/105/1.25
**
*PRINT tempco_m40_125_ppmC
PRINT tempco_m30_85_ppmC
PRINT tempco_m20_85_ppmC

print Iout25

.endc

.lib /foss/pdks/ihp-sg13cmos5l/libs.tech/ngspice/models/cornerMOSlv.lib mos_tt
.lib /foss/pdks/ihp-sg13cmos5l/libs.tech/ngspice/models/cornerMOShv.lib mos_tt
.lib /foss/pdks/ihp-sg13cmos5l/libs.tech/ngspice/models/cornerRES.lib res_typ
.lib /foss/pdks/ihp-sg13cmos5l/libs.tech/ngspice/models/cornerDIO.lib dio_tt
.lib /foss/pdks/ihp-sg13cmos5l/libs.tech/ngspice/models/cornerPNP.lib typ

**** end user architecture code
**.ends

**.INCLUDE "sg13cmos5l_srout_tinybgr.spice"
.INCLUDE "slot15_wrapper.spice"
*.INCLUDE "sg13cmos5l_srout_tinybgr_lvs.spice"
*.INCLUDE "sg13cmos5l_srout_tinybgr_pex.spice"
*.INCLUDE "sg13cmos5l_srout_tinybgr_rcx.spice"
