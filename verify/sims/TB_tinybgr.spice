** sch_path: /foss/designs/gits/sg13cmos5l_srout_ip__tinyBGR/xschem/TB_tinybgr.sch
**.subckt TB_tinybgr
Vsup ADD5V 0 PAR_VDD5
C3 VREF 0 10f
Viout1 IOUT1 0 1
xbgrtop ADD5V VREF IOUT1 0 sg13cmos5l_srout_tinybgr
**** begin user architecture code

.option savecurrents
.PARAM PAR_VDD5=3.3
.PARAM PAR_VDDRISE=100e-6
.PARAM PAR_POFF=0
.PARAM PAR_NOFF=0
.OPTION TEMP=27

.control
run
save all

op
**write tb_bgr_op.raw
** To find model parameters type display in ngspice prompt
**print @n.xbgrtop.xmn1.nsg13_hv_nmos[ids] @n.xbgrtop.xmn1.nsg13_hv_nmos[gm]
**print @n.xbgrtop.xmp1.nsg13_hv_pmos[ids] @n.xbgrtop.xmp1.nsg13_hv_pmos[gm]
**LET gmidmn1=@n.xbgrtop.xmn1.nsg13_hv_nmos[gm]/@n.xbgrtop.xmn1.nsg13_hv_nmos[ids]
**LET gmidmp1=@n.xbgrtop.xmp1.nsg13_hv_pmos[gm]/@n.xbgrtop.xmp1.nsg13_hv_pmos[ids]
**print gmidmn1 gmidmp1
**print @q.xbgrtop.xq2.qpnpmpa[ie] @q.xbgrtop.xq1.qpnpmpa[ie]
* dc Vref 3.3 1.5 -0.1
DC TEMP -30 125 1
**write dc.raw
PLOT V(VREF)
**PLOT I(VIOUT1)
** PLOT @n.xbgrtop.xmnsu1.nsg13_hv_nmos[ids]
**PLOT @n.xbgrtop.xmnsu2.nsg13_hv_nmos[ids]
**PLOT V(xbgrtop.vgsu1)
** Calculating tempco
*MEAS DC vrefMAX_m40to125 MAX V(VREF) FROM=-40 TO=125
*MEAS DC vrefMIN_m40to125 MIN V(VREF) FROM=-40 TO=125
MEAS DC vrefMAX_m30to85 MAX V(VREF) FROM=-30 TO=85
MEAS DC vrefMIN_m30to85 MIN V(VREF) FROM=-30 TO=85
MEAS DC vrefMAX_m20to85 MAX V(VREF) FROM=-20 TO=85
MEAS DC vrefMIN_m20to85 MIN V(VREF) FROM=-20 TO=85
MEAS DC Iout25 FIND I(VIOUT1) At=25

*LET tempco_m40_125_ppmC=1e6*(vrefMAX_m40to125 - vrefMIN_m40to125)/165/1.25
LET tempco_m30_85_ppmC=1e6*(vrefMAX_m30to85 - vrefMIN_m30to85)/115/1.25
LET tempco_m20_85_ppmC=1e6*(vrefMAX_m20to85 - vrefMIN_m20to85)/105/1.25
**
*PRINT tempco_m40_125_ppmC
PRINT tempco_m30_85_ppmC
PRINT tempco_m20_85_ppmC

print Iout25

.endc

.lib /foss/pdks/ihp-sg13cmos5l/libs.tech/ngspice/models/cornerMOSlv.lib mos_tt
.lib /foss/pdks/ihp-sg13cmos5l/libs.tech/ngspice/models/cornerMOShv.lib mos_tt
.lib /foss/pdks/ihp-sg13cmos5l/libs.tech/ngspice/models/cornerRES.lib res_typ
.lib /foss/pdks/ihp-sg13cmos5l/libs.tech/ngspice/models/cornerDIO.lib dio_tt
.lib /foss/pdks/ihp-sg13cmos5l/libs.tech/ngspice/models/cornerPNP.lib typ

**** end user architecture code
**.ends

*.INCLUDE "sg13cmos5l_srout_tinybgr_lvs.spice"
*.INCLUDE "sg13cmos5l_srout_tinybgr_pex.spice"
.INCLUDE "sg13cmos5l_srout_tinybgr_rcx.spice"
